// 2MHz coarse oscillator; all digital stages are unmodified HD cells.
simulator lang=spectre
subckt osc_2m (AVDD AVSS CLKO IBN2U)
MNREF (IBN2U IBN2U AVSS AVSS) n18 w=0.28u l=1u m=4
MNBP (VBP IBN2U AVSS AVSS) n18 w=0.28u l=1u
MPREF (VBP VBP AVDD AVDD) p18 w=1.28u l=1u
MPS1 (P1 VBP AVDD AVDD) p18 w=1.28u l=1u m=2
XINV1 (N3 N1 P1 Q1 AVDD AVSS) INHDVL
MNS1 (Q1 IBN2U AVSS AVSS) n18 w=0.28u l=1u m=2
CT1 (N1 AVDD) mim w=10u l=7.75u
MPS2 (P2 VBP AVDD AVDD) p18 w=1.28u l=1u m=2
XINV2 (N1 N2 P2 Q2 AVDD AVSS) INHDVL
MNS2 (Q2 IBN2U AVSS AVSS) n18 w=0.28u l=1u m=2
CT2 (N2 AVSS) mim w=10u l=7.75u
MPS3 (P3 VBP AVDD AVDD) p18 w=1.28u l=1u m=2
XINV3 (N2 N3 P3 Q3 AVDD AVSS) INHDVL
MNS3 (Q3 IBN2U AVSS AVSS) n18 w=0.28u l=1u m=2
CT3 (N3 AVSS) mim w=10u l=7.75u
XBUF0 (N3 B1 AVDD AVSS AVDD AVSS) INHDVL
XBUF1 (B1 CLKO AVDD AVSS AVDD AVSS) INHDV0
ends osc_2m
