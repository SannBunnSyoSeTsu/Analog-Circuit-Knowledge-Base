simulator lang=spectre
subckt inv (in out vdd vss)
XG (in out vdd vss vdd vss) INHDV1
ends inv
subckt nand (a b q vdd vss)
XG (a b q vdd vss vdd vss) NAND2HDV1
ends nand
subckt delay_chain (in out vdd vss)
XD0 (in d0 vdd vss vdd vss) INHDV1
CD0 (d0 vss) mim w=10u l=11u
XD1 (d0 d1 vdd vss vdd vss) INHDV1
CD1 (d1 vss) mim w=10u l=11u
XD2 (d1 d2 vdd vss vdd vss) INHDV1
CD2 (d2 vss) mim w=10u l=11u
XD3 (d2 d3 vdd vss vdd vss) INHDV1
CD3 (d3 vss) mim w=10u l=11u
XD4 (d3 d4 vdd vss vdd vss) INHDV1
CD4 (d4 vss) mim w=10u l=11u
XD5 (d4 d5 vdd vss vdd vss) INHDV1
CD5 (d5 vss) mim w=10u l=11u
XD6 (d5 d6 vdd vss vdd vss) INHDV1
CD6 (d6 vss) mim w=10u l=11u
XD7 (d6 out vdd vss vdd vss) INHDV1
CD7 (out vss) mim w=10u l=11u
ends delay_chain
subckt non_overlap (clk p1 p2 vdd vss)
XI5 (net03 p2 vdd vss) inv
XI0 (clk net5 vdd vss) inv
XI3 (p1 clk net4 vdd vss) nand
XI1 (net5 net03 net6 vdd vss) nand
XI4 (net4 net03 vdd vss) delay_chain
XI2 (net6 p1 vdd vss) delay_chain
ends non_overlap
subckt buffer (in out vdd vss)
XB0_0 (in b0 vdd vss vdd vss) INHDV16
XB1_0 (b0 b1 vdd vss vdd vss) INHDV32
XB2_0 (b1 b2 vdd vss vdd vss) INHDV32
XB2_1 (b1 b2 vdd vss vdd vss) INHDV32
XB3_0 (b2 out vdd vss vdd vss) INHDV32
XB3_1 (b2 out vdd vss vdd vss) INHDV32
XB3_2 (b2 out vdd vss vdd vss) INHDV32
XB3_3 (b2 out vdd vss vdd vss) INHDV32
XB3_4 (b2 out vdd vss vdd vss) INHDV32
XB3_5 (b2 out vdd vss vdd vss) INHDV32
XB3_6 (b2 out vdd vss vdd vss) INHDV32
XB3_7 (b2 out vdd vss vdd vss) INHDV32
ends buffer
subckt buffers (in out vdd vss)
XB0_0 (in b0 vdd vss vdd vss) INHDV1
XB1_0 (b0 b1 vdd vss vdd vss) INHDV4
XB2_0 (b1 b2 vdd vss vdd vss) INHDV16
XB3_0 (b2 out vdd vss vdd vss) INHDV32
XB3_1 (b2 out vdd vss vdd vss) INHDV32
ends buffers
subckt lvl3 (in out vdd1 vdd2 vss)
Mlvl3_PM3 (out net14 vdd2 vdd2) p33 w=0.4u l=0.36u m=1
Mlvl3_PM1 (net3 net14 vdd2 vdd2) p33 w=0.4u l=0.36u m=1
Mlvl3_PM0 (net14 net3 vdd2 vdd2) p33 w=0.4u l=0.36u m=1
XCOREINV (in net1 vdd1 vss vdd1 vss) INHDV1
Mlvl3_NM3 (out net14 vss vss) n33 w=1.08u l=0.36u m=1
Mlvl3_NM2 (net14 in vss vss) n33 w=4.32u l=0.36u m=1
Mlvl3_NM1 (net3 net1 vss vss) n33 w=4.32u l=0.36u m=1
ends lvl3
subckt bootstrap_driver (GN GN2 IN VBST VDD VLX VSS VSW)
XLVL3 (p1_int P1UP VDD VBST VSS) lvl3
XINV34 (net03 net016 VBST VLX) inv
XINV31 (net028 net02 VDD VSS) inv
XINV17 (net08 p1_int VDD VSS) inv
XBUFF12 (net028 GN2 VDD VSS) buffer
XBUFF11 (net016 GN VBST VLX) buffer
Mbootstrap_driver_NM1 (VLX net16 VSS VSS) n18 w=63.30706667u l=0.18u m=3
Mbootstrap_driver_NM5 (net03 P1UP VLX VLX) n33 w=1.08u l=0.36u m=1
Mbootstrap_driver_NM2 (VSW GN VLX VSS) n33 w=87.90971429u l=0.36u m=7
Mbootstrap_driver_PM5 (net03 P1UP VBST VBST) p33 w=0.4u l=0.36u m=1
Mbootstrap_driver_PM2 (VDD charge_gate VBST VBST) p33 w=79.07285714u l=0.36u m=7
CBST (VBST VLX) mim w=30u l=30u m=1
MBSTCAP (VLX VBST VLX VLX) n18 w=80u l=9.6u m=34
MTRACKP (VSW VSS VLX VLX) p33 w=89.27580645u l=0.36u m=124
XNON (IN net08 net028 VDD VSS) non_overlap
XBUFF7 (net028 net16 VDD VSS) buffers
XCHARGE_LS (net02 CHUP VDD VBST VSS) lvl3
MCHN (charge_inv CHUP VLX VLX) n33 w=1.08u l=0.36u m=1
MCHP (charge_inv CHUP VBST VBST) p33 w=0.4u l=0.36u m=1
XINVCH (charge_inv charge_noninv VBST VLX) inv
XBUFFCH (charge_noninv charge_gate VBST VLX) buffers
ends bootstrap_driver
