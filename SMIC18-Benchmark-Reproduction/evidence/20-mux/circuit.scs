// Three binary TG stages; standard-cell select complements.
simulator lang=spectre
subckt tg (VDD VSS EN ENB I O)
MN (O EN I VSS) n18 w=1.46u l=0.36u
MP (O ENB I VDD) p18 w=6.08u l=0.36u
ends tg
subckt input_mux_8to1 (AVDD AVSS S2 S1 S0 VIN7 VIN6 VIN5 VIN4 VIN3 VIN2 VIN1 VIN0 VO)
XINV0 (S0 SB0 AVDD AVSS AVDD AVSS) INHDV0
XINV1 (S1 SB1 AVDD AVSS AVDD AVSS) INHDV0
XINV2 (S2 SB2 AVDD AVSS AVDD AVSS) INHDV0
XSW0 (AVDD AVSS SB0 S0 VIN0 n0_0) tg
XSW1 (AVDD AVSS S0 SB0 VIN1 n0_0) tg
XSW2 (AVDD AVSS SB0 S0 VIN2 n0_1) tg
XSW3 (AVDD AVSS S0 SB0 VIN3 n0_1) tg
XSW4 (AVDD AVSS SB0 S0 VIN4 n0_2) tg
XSW5 (AVDD AVSS S0 SB0 VIN5 n0_2) tg
XSW6 (AVDD AVSS SB0 S0 VIN6 n0_3) tg
XSW7 (AVDD AVSS S0 SB0 VIN7 n0_3) tg
XSW8 (AVDD AVSS SB1 S1 n0_0 n1_0) tg
XSW9 (AVDD AVSS S1 SB1 n0_1 n1_0) tg
XSW10 (AVDD AVSS SB1 S1 n0_2 n1_1) tg
XSW11 (AVDD AVSS S1 SB1 n0_3 n1_1) tg
XSW12 (AVDD AVSS SB2 S2 n1_0 VO) tg
XSW13 (AVDD AVSS S2 SB2 n1_1 VO) tg
ends input_mux_8to1
