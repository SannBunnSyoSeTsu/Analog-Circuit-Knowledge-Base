simulator lang=spectre
subckt fa_comp (clk vinp vinn outp outn vdd vss)
MTAIL (tail clk vss vss) n18 w=8.14u l=.18u
MIN1 (dx vinp tail vss) n18 w=9.02u l=.18u
MIN2 (dy vinn tail vss) n18 w=9.02u l=.18u
MNL1 (outn outp dx vss) n18 w=4.06u l=.18u
MNL2 (outp outn dy vss) n18 w=4.06u l=.18u
MPL1 (outn outp vdd vdd) p18 w=6.12u l=.18u
MPL2 (outp outn vdd vdd) p18 w=6.12u l=.18u
MPC1 (outn clk vdd vdd) p18 w=6.12u l=.18u
MPC2 (outp clk vdd vdd) p18 w=6.12u l=.18u
MPC3 (dx clk vdd vdd) p18 w=6.12u l=.18u
MPC4 (dy clk vdd vdd) p18 w=6.12u l=.18u
ends fa_comp
subckt fa_sr (sn rn q qb vdd vss)
XG1 (sn qb q vdd vss vdd vss) NAND2HDV1
XG2 (rn q qb vdd vss vdd vss) NAND2HDV1
ends fa_sr
subckt flash_adc_3bit (vss vdd vrefn vrefp clk vin b2 b1 b0)
RL1 (t1 vrefn) resistor r=500
RL2 (t2 t1) resistor r=500
RL3 (t3 t2) resistor r=500
RL4 (t4 t3) resistor r=500
RL5 (t5 t4) resistor r=500
RL6 (t6 t5) resistor r=500
RL7 (t7 t6) resistor r=500
RL8 (vrefp t7) resistor r=500
CT1 (t1 vss) capacitor c=0.3p
XC1 (clk vin t1 cp1 cn1 vdd vss) fa_comp
XS1 (cn1 cp1 q1 qb1 vdd vss) fa_sr
CT2 (t2 vss) capacitor c=0.3p
XC2 (clk vin t2 cp2 cn2 vdd vss) fa_comp
XS2 (cn2 cp2 q2 qb2 vdd vss) fa_sr
CT3 (t3 vss) capacitor c=0.3p
XC3 (clk vin t3 cp3 cn3 vdd vss) fa_comp
XS3 (cn3 cp3 q3 qb3 vdd vss) fa_sr
CT4 (t4 vss) capacitor c=0.3p
XC4 (clk vin t4 cp4 cn4 vdd vss) fa_comp
XS4 (cn4 cp4 q4 qb4 vdd vss) fa_sr
CT5 (t5 vss) capacitor c=0.3p
XC5 (clk vin t5 cp5 cn5 vdd vss) fa_comp
XS5 (cn5 cp5 q5 qb5 vdd vss) fa_sr
CT6 (t6 vss) capacitor c=0.3p
XC6 (clk vin t6 cp6 cn6 vdd vss) fa_comp
XS6 (cn6 cp6 q6 qb6 vdd vss) fa_sr
CT7 (t7 vss) capacitor c=0.3p
XC7 (clk vin t7 cp7 cn7 vdd vss) fa_comp
XS7 (cn7 cp7 q7 qb7 vdd vss) fa_sr
XE1 (q2 n2 vdd vss vdd vss) INHDV1
XE2 (q4 n4 vdd vss vdd vss) INHDV1
XE3 (q6 n6 vdd vss vdd vss) INHDV1
XE4 (q7 n7 vdd vss vdd vss) INHDV1
XE5 (q2 n4 x1 vdd vss vdd vss) NAND2HDV1
XE6 (n6 x1 b1 vdd vss vdd vss) NAND2HDV1
XE7 (q5 n6 y1 vdd vss vdd vss) NAND2HDV1
XE8 (q3 n4 y2 vdd vss vdd vss) NAND2HDV1
XE9 (q1 n2 y3 vdd vss vdd vss) NAND2HDV1
XE10 (n7 y1 y2 y3 b0 vdd vss vdd vss) NAND4HDV1
XE11 (q4 d4 vdd vss vdd vss) INHDV1
XE12 (d4 b2 vdd vss vdd vss) INHDV1
ends flash_adc_3bit
